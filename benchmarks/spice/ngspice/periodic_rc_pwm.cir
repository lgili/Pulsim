* Periodic RC + PWM — ngspice benchmark
* Matches Pulsim benchmarks/circuits/periodic_rc_pwm.yaml
*
* PWM source: 50 kHz, 50% duty, 200 ns dead-time (rise+fall).
*   period   = 1 / 50 kHz       = 20 µs
*   on-time  = period * duty    = 10 µs
*   rise/fall = dead_time/2 ea. = 200 ns each (matched)
* PULSE(V1 V2 TD TR TF PW PER) — pulse width is high-time excluding
* rise/fall, so PW = on-time - dead_time/2 = 9.6 µs to be safe.
*
* Pulsim contract: max_error ≤ 1.1e-1 vs the reference baseline.

V1 in 0 PULSE(0 5 0 200n 200n 9.6u 20u)
R1 in out 100
C1 out 0 1u IC=0

* No UIC: align with Pulsim, which uses the DC operating point as IC.
.tran 0.5u 200u
.end
