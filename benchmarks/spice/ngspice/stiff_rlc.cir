* Stiff RLC step response — ngspice benchmark
* Matches Pulsim benchmarks/circuits/stiff_rlc.yaml
*
* DC source on a small LC tank: L=1uH, C=1nF gives ω_n ≈ 31.6 Mrad/s
* (≈ 5 MHz) — stiff for explicit integrators, fine for trapezoidal.
* Pulsim contract: max_error ≤ 5e-2 vs the reference baseline.

V1 in 0 DC 5
R1 in n1 1
L1 n1 out 1u IC=0
C1 out 0 1n IC=0

* No UIC: align with Pulsim, which uses the DC operating point as IC.
* For this DC-driven RLC, that means V(out) = 5 V at t=0 and stays
* there — the test exercises sustained equilibrium on a stiff network,
* not the underdamped transient.
.tran 50n 50u
.end
