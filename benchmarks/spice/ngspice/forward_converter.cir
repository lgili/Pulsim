* Single-switch forward converter — ngspice benchmark
* Matches Pulsim benchmarks/circuits/forward_converter.yaml.
*
* Unlike a flyback, the transformer (1:1, K=0.95) here just
* couples power directly during the ON time. duty=0.4 → V_out
* ≈ V_in · duty = 9.6 V on a 5 Ω load.

Vin vin 0 DC 24
Vg  gate 0 PULSE(0 10 0 1n 1n 8u 20u)

* Primary switch
SW sw_drain 0 gate 0 SWMOD
.model SWMOD SW(VT=5 VH=0.1 RON=5m ROFF=1Meg)

* Transformer (1:1, K=0.95)
L1 vin sw_drain 200u
L2 sec_p sec_n  200u
K1 L1 L2 0.95

* Secondary returns to ground via tiny resistor (DC-coupled)
R_st sec_n 0 1m

* Rectifier + freewheel diodes (emulated as switches on own V_ak)
SDrect sec_p n_lo sec_p n_lo DMOD
SDfw   0     n_lo 0     n_lo DMOD
.model DMOD SW(VT=0 VH=1m RON=5m ROFF=1Meg)

* Output filter + load
L_o n_lo out 47u IC=0
C_o out 0   100u IC=0
Rload out 0 5

.tran 0.1u 2m UIC
.end
