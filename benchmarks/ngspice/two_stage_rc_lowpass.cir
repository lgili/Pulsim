* Two-stage RC low-pass filter — ngspice benchmark
* Matches Pulsim benchmarks/circuits/two_stage_rc_lowpass.yaml
*
* Stage 1: R1=1kΩ, C1=100nF, τ1=100µs
* Stage 2: R2=1kΩ, C2=100nF, τ2=100µs
* Cascaded → 2nd order, not just product of two 1st orders (loading effect).

Vp  in  0   PULSE(0 5 0 1n 1n 10m 20m)
R1  in  mid 1k
C1  mid 0   100n IC=0
R2  mid out 1k
C2  out 0   100n IC=0

.tran 5u 5m UIC
.end
